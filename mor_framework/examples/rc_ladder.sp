* RC ladder network — 20-stage RC ladder
R1 1 2 100
C1 2 0 1e-12
R2 2 3 100
C2 3 0 1e-12
R3 3 4 100
C3 4 0 1e-12
R4 4 5 100
C4 5 0 1e-12
R5 5 6 100
C5 6 0 1e-12
R6 6 7 100
C6 7 0 1e-12
R7 7 8 100
C7 8 0 1e-12
R8 8 9 100
C8 9 0 1e-12
R9 9 10 100
C9 10 0 1e-12
R10 10 11 100
C10 11 0 1e-12
R11 11 12 100
C11 12 0 1e-12
R12 12 13 100
C12 13 0 1e-12
R13 13 14 100
C13 14 0 1e-12
R14 14 15 100
C14 15 0 1e-12
R15 15 16 100
C15 16 0 1e-12
R16 16 17 100
C16 17 0 1e-12
R17 17 18 100
C17 18 0 1e-12
R18 18 19 100
C18 19 0 1e-12
R19 19 20 100
C19 20 0 1e-12
R20 20 21 100
C20 21 0 1e-12
V1 1 0 DC 0 AC 1 PULSE(0 1 0 1e-11 1e-11 1e-9 2e-9)
.TRAN 1e-12 1e-9
.AC DEC 50 1e3 1e11
.PRINT V(21)
.END
